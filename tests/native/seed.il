; Opt-in only: creates eval_ic in a NEW disposable project. Never run in a user project.
load(getShellEnvVar("CADEX_TEST_RECIPES"))
when(ddGetObj("eval_ic") error("Refusing existing eval_ic; use a new disposable project"))
ddCreateLib("eval_ic" strcat(getWorkingDir() "/eval_ic"))
techBindTechFile(ddGetObj("eval_ic") "gpdk180")
procedure(evalPin(inst term)
 let((p box)
 p=car(setof(tt inst~>master~>terminals tt~>name==term))
 unless(p error("fixture pin is missing"))
 box=dbTransformBBox(car(p~>pins)~>fig~>bBox inst~>transform)
 list((caar(box)+caadr(box))/2.0 (cadar(box)+cadadr(box))/2.0)
 ))
procedure(evalGround(cv source name x y)
 let((g p q)
 g=dbCreateInst(cv dbOpenCellViewByType("analogLib" "gnd" "symbol" "" "r") name list(x y) "R0")
 p=evalPin(source "MINUS") q=evalPin(g car(g~>master~>terminals)~>name)
 unless(schCreateWire(cv "draw" "full" list(p q) .0625 .0625 0) error("fixture ground wire failed"))
 ))
let((cadexCV i cdf check)
 cadexCV=dbOpenCellViewByType("eval_ic" "bias_demo" "schematic" "schematic" "w")
 foreach(spec '(("M0" (5 3) "10u" "1u"))
  i=dbCreateInst(cadexCV dbOpenCellViewByType("gpdk180" "nmos" "symbol" "" "r") car(spec) cadr(spec) "R0")
  vfoSetParam(cdfGetInstCDF(i) "w" caddr(spec))
  vfoSetParam(cdfGetInstCDF(i) "l" nth(3 spec))
 )
 printf("SEED_MOS_CREATED\n")
 cadexStub("M0" "D" "DOUT" .5)
 cadexStub("M0" "G" "BIAS" .5)
 cadexStub("M0" "S" "gnd!" .5)
 cadexStub("M0" "B" "gnd!" .5)
 printf("SEED_SOURCE_NEXT\n")
 i=dbCreateInst(cadexCV dbOpenCellViewByType("analogLib" "vdc" "symbol" "" "r") "VBIAS" '(1 3) "R0")
 dbReplaceProp(i "vdc" "string" "0.8")
 cadexStub("VBIAS" "PLUS" "BIAS" .5)
 evalGround(cadexCV i "G0" 1 1.5)
 printf("SEED_SOURCE_NEXT\n")
 i=dbCreateInst(cadexCV dbOpenCellViewByType("analogLib" "vdc" "symbol" "" "r") "VOUT" '(8 3) "R0")
 dbReplaceProp(i "vdc" "string" "1.0")
 cadexStub("VOUT" "PLUS" "DOUT" .5)
 evalGround(cadexCV i "G1" 8 1.5)
 check=schCheck(cadexCV)
 printf("SEED_BIAS_CHECK %L\n" check)
 unless(car(check)==0 error("fixture bias check failed"))
 unless(dbSave(cadexCV) error("fixture save failed"))
 dbClose(cadexCV)
 cadexCV=dbOpenCellViewByType("eval_ic" "mirror_core" "schematic" "schematic" "w")
 foreach(spec '(("MREF" (2 3) ("REF" "REF" "VSS" "VSS")) ("MOUT" (5 3) ("OUT" "REF" "VSS" "VSS")))
  i=dbCreateInst(cadexCV dbOpenCellViewByType("gpdk180" "nmos" "symbol" "" "r") car(spec) cadr(spec) "R0")
  vfoSetParam(cdfGetInstCDF(i) "w" "4u")
  vfoSetParam(cdfGetInstCDF(i) "l" "1u")
  cadexStub(car(spec) "D" car(caddr(spec)) .5)
  cadexStub(car(spec) "G" cadr(caddr(spec)) .5)
  cadexStub(car(spec) "S" caddr(caddr(spec)) .5)
  cadexStub(car(spec) "B" nth(3 caddr(spec)) .5)
 )
 foreach(spec '(("REF" "inputOutput" (0 3)) ("OUT" "inputOutput" (7 3)) ("VSS" "inputOutput" (0 0)))
  schCreatePin(cadexCV nil car(spec) cadr(spec) nil caddr(spec) "R0")
  let((p end wire)
   p=caddr(spec) end=list(car(p)+.5 cadr(p))
   wire=car(schCreateWire(cadexCV "draw" "full" list(p end) .0625 .0625 0))
   schCreateWireLabel(cadexCV wire end car(spec) "lowerLeft" "R0" "stick" .0625 nil)
  )
 )
 check=schCheck(cadexCV)
 printf("SEED_MIRROR_CHECK %L\n" check)
 unless(car(check)==0 error("fixture mirror check failed"))
 unless(dbSave(cadexCV) error("fixture save failed"))
 dbClose(cadexCV)
)
