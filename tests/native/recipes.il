; Requires tests/native/seed.il in a disposable project and CADEX_TEST_RECIPES.
load(getShellEnvVar("CADEX_TEST_RECIPES"))
let((cadexCV source ground upper lower label before bad out count)
 cadexCV=dbOpenCellViewByType("eval_ic" "bias_demo" "schematic" "" "a")
 source=cadexInst("VBIAS") ground=cadexInst("G0")
 upper=car(setof(s cadexCV~>shapes s~>objType=="line" && s~>points==list(1:3 1:3.5)))
 lower=car(setof(s cadexCV~>shapes s~>objType=="line" && s~>points==list(1:1.5 1:2.625)))
 unless(upper && lower error("Native test fixture geometry changed"))
 label=car(upper~>children)
 unless(label && label~>theLabel=="BIAS" error("Native test label missing"))
 before=source~>xy
 bad=errset(cadexMoveFigures(list(source nil) 0:-.25) nil)
 unless(!bad && source~>xy==before error("Invalid group changed geometry"))
 count=cadexMoveFigures(list(source ground upper lower label label) 0:-.25)
 unless(count==4 && source~>xy==list(1.0 2.75) && ground~>xy==list(1.0 1.25) && label~>xy==list(1.0 3.25)
  error("Ownership group moved incorrectly"))
 bad=errset(cadexDeleteWire(upper~>points) nil)
 unless(!bad && label~>parent==upper error("Labeled delete was not refused"))
 bad=errset(cadexStretchWire(upper~>points list(1:2.75 2:3.5)) nil)
 unless(!bad && upper~>points==list(1:2.75 1:3.25) error("Invalid stretch mutated geometry"))
 cadexStretchWire(upper~>points list(1:2.75 1:3.5))
 unless(label~>parent==upper && label~>xy==list(1.0 3.5) && label~>theLabel=="BIAS"
  error("Stretch lost label ownership or anchor"))
 cadexParam("VBIAS" "dc" "0.7")
 unless(source~>vdc=="0.7" error("Actual source property differs"))
 bad=errset(cadexParam("VBIAS" "typo" "9") nil)
 unless(!bad && source~>vdc=="0.7" error("Invalid parameter mutated source"))
 cadexParam("M0" "w" "12u")
 unless(cdfFindParamByName(cdfGetInstCDF(cadexInst("M0")) "w")~>value=="12u" error("MOS callback readback failed"))
 unless(car(schCheck(cadexCV))==0 error("Native schematic check failed"))
 unless(dbSave(cadexCV) error("Native test save failed"))
 out=outfile(strcat(getShellEnvVar("CODEX_VIRTUOSO_RUN") "/recipes-proof.txt"))
 fprintf(out "NATIVE_RECIPES_PASS\nMOVE_ROOTS %d\nLABEL %L %L\nVDC %L\nMOS_W %L\n" count label~>theLabel label~>xy cdfFindParamByName(cdfGetInstCDF(source) "vdc")~>value cdfFindParamByName(cdfGetInstCDF(cadexInst("M0")) "w")~>value)
 close(out)
)
